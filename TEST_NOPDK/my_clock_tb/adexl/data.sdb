ADE simulation setup
Run mode: Single Run, Sweeps and Corners
Tests:
  TEST_NOPDK:my_clock_tb:1: TEST_NOPDK/my_clock_tb/config, simulator ams
